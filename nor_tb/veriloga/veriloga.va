// Created Tue Jan 20 16:50:34 2026

`include "constants.vams"
`include "disciplines.vams"

module nor_tb ();

  analog begin

  end
endmodule
